;;; snm_dc.ocn - DC sweep of the SNM test cell (both half-cell VTCs in one run).
;;; Usage:  ocnCell = "simple_6t_sram_cell_snm_read"  ocnTag = "tt27"  load("ocean/snm_dc.ocn")   (run from vm_work/)
;;; Optional: ocnLib, ocnTemp (27), ocnSection ("NN"), ocnStep (0.01), ocnVdd (1.2)
unless(boundp('ocnLib)     ocnLib = "version_90nm_sram_puf")
unless(boundp('ocnTemp)    ocnTemp = 27)
unless(boundp('ocnSection) ocnSection = "NN")
unless(boundp('ocnStep)    ocnStep = 0.01)
unless(boundp('ocnVdd)     ocnVdd = 1.2)
unless(boundp('ocnTag)     ocnTag = "tt27")
system("mkdir -p ../cadence_vm/results")
unless(boundp('ocnPre) ocnPre = "")
simulator('spectre)
design(ocnLib ocnCell "schematic")
resultsDir(sprintf(nil "%s/runs/%s_%s" getWorkingDir() ocnCell ocnTag))
if(boundp('ocnModelFile) then modelFile(list(ocnModelFile)) else modelFile(list(strcat(or(getShellEnvVar("PDK") "/home/buet/cadence/gpdk090_v4.6") "/models/spectre/gpdk090.scs") ocnSection)))
desVar("vin" 0.0)
analysis('dc ?param "vin" ?start 0 ?stop ocnVdd ?step ocnStep)
temp(ocnTemp)
save("all")
createNetlist(?recreateAll t ?display nil)
run()
selectResult("dc")
ocnPrint(?output sprintf(nil "../cadence_vm/results/%s%s_%s_vtc.txt" ocnPre ocnCell ocnTag) ?numberNotation 'scientific ?numSpaces 1
         v("/Q") v("/Q_bar"))
exit
