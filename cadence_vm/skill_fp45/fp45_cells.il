;;; fp45_cells.il - 6T cell, its testbench (the stimulus of the hand-drawn gpdk090 tb) and the SNM test cells.
load("skill_fp45/config.il")
load("skill/util.il")
load("skill_fp45/fp45_overrides.il")
load("skill/snm_cells.il")

procedure(sp_make_cell6t()
  let((lib cv nm pm ipin iopin inst)
    lib = sp_ensure_lib(spLib spLibPath spTechLib)
    cv = dbOpenCellViewByType(spLib "simple_6t_sram_cell" "schematic" "schematic" "w")
    nm = dbOpenCellViewByType(spTechLib spNmos "symbol")
    pm = dbOpenCellViewByType(spTechLib spPmos "symbol")
    ipin  = dbOpenCellViewByType("basic" "ipin" "symbol")
    iopin = dbOpenCellViewByType("basic" "iopin" "symbol")
    foreach(d list(
        list("PM0" pm spWpu list(0 4)   list("Q"      "Q_bar" "VDD" "VDD"))
        list("PM1" pm spWpu list(6 4)   list("Q_bar"  "Q"     "VDD" "VDD"))
        list("NM0" nm spWpd list(0 0)   list("Q"      "Q_bar" "GND" "GND"))
        list("NM1" nm spWpd list(6 0)   list("Q_bar"  "Q"     "GND" "GND"))
        list("NM2" nm spWpg list(-4 0)  list("BL"     "Wl"    "Q"     "GND"))
        list("NM3" nm spWpg list(10 0)  list("BL_bar" "Wl"    "Q_bar" "GND")))
      let((c)
        inst = schCreateInst(cv cadr(d) car(d) nth(3 d) "R0")
        sp_mos_params(inst caddr(d) spL)
        c = nth(4 d)
        sp_label_term(cv inst "D" nth(0 c)) sp_label_term(cv inst "G" nth(1 c))
        sp_label_term(cv inst "S" nth(2 c)) sp_label_term(cv inst "B" nth(3 c))))
    foreach(p list(list("Wl" ipin "input" list(-8 -4)) list("BL" iopin "inputOutput" list(-8 -6))
                   list("BL_bar" iopin "inputOutput" list(-8 -8)) list("VDD" iopin "inputOutput" list(-8 -10))
                   list("GND" iopin "inputOutput" list(-8 -12)))
      schCreatePin(cv cadr(p) car(p) caddr(p) nil cadddr(p) "R0")
      let((w pt)
        pt = list(xCoord(cadddr(p))+0.5 yCoord(cadddr(p)))
        w = car(schCreateWire(cv "route" "full" list(cadddr(p) pt) 0.0625 0.0625 0.0))
        schCreateWireLabel(cv w pt car(p) "centerLeft" "R0" "stick" 0.2 nil)))
    schCheck(cv)
    dbSave(cv)
    sp_log("schematic simple_6t_sram_cell saved (%d instances)" length(cv~>instances))
    dbClose(cv)
    schPinListToSymbol(spLib "simple_6t_sram_cell" "symbol" schSchemToPinList(spLib "simple_6t_sram_cell" "schematic"))
    sp_log("symbol simple_6t_sram_cell created")
    t))

;;; same stimulus as the gpdk090 tb_simple_6t_sram_cell, scaled to Vdd: write 1 (BL_bar low), then read
procedure(sp_make_tb()
  let((cv cell pc v)
    v = sprintf(nil "%g" spVdd)
    cv = dbOpenCellViewByType(spLib "tb_simple_6t_sram_cell" "schematic" "schematic" "w")
    cell = dbOpenCellViewByType(spLib "simple_6t_sram_cell" "symbol")
    pc = schCreateInst(cv cell "I0" list(0 0) "R0")
    sp_label_term(cv pc "Wl" "net3") sp_label_term(cv pc "BL" "net1") sp_label_term(cv pc "BL_bar" "net2")
    sp_label_term(cv pc "VDD" "vdd!") sp_label_term(cv pc "GND" "gnd!")
    sp_vdc(cv "V0" list(-8 -6) "vdd!" "gnd!" spVdd)
    sp_vpwl(cv "V1" list(-4 -6) "net3" "gnd!" list(list("0" "0") list("1n" "0") list("1.1n" v) list("3n" v) list("3.1n" "0")
        list("8n" "0") list("8.1n" v) list("10n" v) list("10.1n" "0") list("12n" "0")))
    sp_vpwl(cv "V2" list(0 -6) "net2" "gnd!" list(list("0" v) list("900.0p" v) list("1n" "0") list("3n" "0") list("3.1n" v) list("12n" v)))
    sp_vpwl(cv "V3" list(4 -6) "net1" "gnd!" list(list("0" v) list("12n" v)))
    schCheck(cv)
    dbSave(cv)
    sp_log("testbench saved (%d instances)" length(cv~>instances))
    dbClose(cv)
    t))

sp_make_cell6t()
sp_make_tb()
sp_make_snm("simple_6t_sram_cell_snm_hold" "hold")
sp_make_snm("simple_6t_sram_cell_snm_read"  "read")
sp_make_snm("simple_6t_sram_cell_snm_write" "write")
exit()
